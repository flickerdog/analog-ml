* NMOS hello world, trimmed models
.option scale=1.0u
.include /home/fatdog/.ciel/sky130A/libs.tech/ngspice/parameters/lod.spice
.param mc_mm_switch=0
.param mc_pr_switch=0
.param lv_dlc_rotweak = .00e-9
.param sky130_fd_pr__nfet_01v8__dlc_rotweak = lv_dlc_rotweak
.param sky130_fd_pr__pfet_01v8__dlc_rotweak = lv_dlc_rotweak
.include /home/fatdog/.ciel/sky130A/libs.ref/sky130_fd_pr/spice/sky130_fd_pr__nfet_01v8__tt.pm3.spice
.include /home/fatdog/.ciel/sky130A/libs.ref/sky130_fd_pr/spice/sky130_fd_pr__nfet_01v8__mismatch.corner.spice
.include /home/fatdog/.ciel/sky130A/libs.ref/sky130_fd_pr/spice/sky130_fd_pr__pfet_01v8__tt.corner.spice
.include /home/fatdog/.ciel/sky130A/libs.ref/sky130_fd_pr/spice/sky130_fd_pr__pfet_01v8__mismatch.corner.spice

Vds d 0 0.9
Vgs g 0 0
XM1 d g 0 0 sky130_fd_pr__nfet_01v8 W=1 L=0.15

.dc Vgs 0 1.8 0.05

.control
run
wrdata id_trim.txt i(Vds)
quit
.endc
.end
